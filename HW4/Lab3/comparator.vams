//Verilog-AMS HDL for "Lab03", "comparator" "verilogams"

`include "constants.vams"
`include "disciplines.vams"

module comparator (in_pos, in_neg, out);
    input in_pos, in_neg;
    electrical in_pos, in_neg;
    output reg out;
    ddiscrete out;

    always begin @(cross(V(in_pos) - V(in_neg), +1)) out = 1; end
    always begin @(cross(V(in_pos) - V(in_neg), -1)) out = 0; end
endmodule
